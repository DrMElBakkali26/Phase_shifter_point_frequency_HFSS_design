# Ansys Electronics Desktop project, version 2023.1
materials:
  Arlon AD1000 (tm): permittivity=10.2 dielectric_loss_tangent=0.0023
  Rogers RT/duroid 5880 (tm): permittivity=2.2 dielectric_loss_tangent=0.0009
  vacuum: permittivity=1

design HFSSDesign (HFSS, HFSS Modal Network, model units mm)
variables:
  w = 4.81mm
  l = 4mm
  h = 0.508mm
  s_l = 60mm
  wo = 1.52mm
  w1 = 0.85mm
  l1 = 1.9mm
  l2 = 0.6mm
  l3 = 0.2mm
  l4 = 4mm
  l5 = 8.5mm
  lamba_4 = 4.25mm
  l6 = 4mm
geometry:
  Substrate [Rogers RT/duroid 5880 (tm)] = box(corner=(-s_l/2, -s_l/2, 0mm), size=(s_l, s_l, h))
  PD1 = rectangle(corner=(-wo/2, -s_l/2, h), x_size=wo, y_size=l)
  Rectangle9 = rectangle(corner=(0mm, -s_l/2+l, h), x_size=-l1, y_size=w1)
  Rectangle10 = rectangle(corner=(-l1, -s_l/2+l+w1, h), x_size=-w1, y_size=l2)
  Rectangle11 = rectangle(corner=(-l1, -s_l/2+l+l2+w1, h), x_size=l3, y_size=w1)
  Rectangle12 = rectangle(corner=(-l1+l3, -s_l/2+l+l2+2*w1, h), x_size=w1, y_size=l3)
  Polyline1 = polyline(z=h, xy: (-l1, -s_l/2+l+w1) (-l1-w1, -s_l/2+l+w1) (-l1, -s_l/2+l) (-l1, -s_l/2+l+w1), closed, covered)
  Polyline2 = polyline(z=h, xy: (-l1, -s_l/2+l+w1+l2) (-l1-w1, -s_l/2+l+w1+l2) (-l1, -s_l/2+l+w1+l2+w1) (-l1, -s_l/2+l+w1+l2), closed, covered)
  Polyline3 = polyline(z=h, xy: (-l1+l3, -s_l/2+l+l2+2*w1) (-l1+l3+w1, -s_l/2+l+l2+2*w1) (-l1+l3, -s_l/2+l+l2+w1) (-l1+l3, -s_l/2+l+l2+2*w1), closed, covered)
  Rectangle9_1 = Rectangle9.duplicate_along_line(step=(l1, 0mm, 0mm), total=2)
  Rectangle10_1 = Rectangle10.duplicate_along_line(step=(2*l1+w1, 0mm, 0mm), total=2)
  Rectangle11_1 = Rectangle11.duplicate_along_line(step=(2*l1-l3, 0mm, 0mm), total=2)
  Rectangle12_1 = Rectangle12.duplicate_along_line(step=(2*l1-2*l3-w1, 0mm, 0mm), total=2)
  Polyline4 = polyline(z=h, xy: (l1, -s_l/2+l +w1) (l1+w1, -s_l/2+l +w1) (l1, -s_l/2+l) (l1, -s_l/2+l +w1), closed, covered)
  Polyline5 = polyline(z=h, xy: (l1, -s_l/2+l+w1+l2) (l1, -s_l/2+l+w1+l2+w1) (l1+w1, -s_l/2+l+w1+l2) (l1, -s_l/2+l+w1+l2), closed, covered)
  Polyline6 = polyline(z=h, xy: (l1-l3, -s_l/2+l+l2+2*w1) (l1-l3 -w1, -s_l/2+l+l2+2*w1) (l1-l3, -s_l/2+l+l2+w1) (l1-l3, -s_l/2+l+l2+2*w1), closed, covered)
  Rectangle13 = rectangle(corner=(-l1+l3-wo/2+w1/2, -s_l/2+l+l2+2*w1+l3, h), x_size=wo, y_size=l4)
  Rectangle13_1 = Rectangle13.duplicate_along_line(step=(2*l1-2*l3-w1, 0mm, 0mm), total=2)
  RLC1 = rectangle(corner=(-l1+l3+w1, -s_l/2+l+l2+2*w1+l3, h), x_size=2*l1-2*l3-2*w1, y_size=-0.15mm)
  port1 = rectangle(corner=(-wo/2, -s_l/2, 0mm), z_size=h, x_size=wo)
  GroundPlane [Arlon AD1000 (tm)] = object_from(Substrate.face(-z))
  Port2 = rectangle(corner=(-l1+l3-wo/2+w1/2, -s_l/2+l+l2+2*w1+l4+l3, h), z_size=-h, x_size=wo)
  port3 = Port2.duplicate_along_line(step=(2*l1-2*l3-w1, 0mm, 0mm), total=2)
  PD1.unite(Polyline1..Polyline6, Rectangle9, Rectangle9_1, Rectangle10, Rectangle10_1, Rectangle11, Rectangle11_1, Rectangle12, Rectangle12_1, Rectangle13, Rectangle13_1)
  Rectangle20 = rectangle(corner=(-l1+l3-wo/2+w1/2, -s_l/2+l+l2+2*w1+l3+l4, h), x_size=-l5, y_size=wo)
  Rectangle20_1 = Rectangle20.duplicate_along_line(step=(l5+2*l1-2*l3-w1+wo, 0mm, 0mm), total=2)
  Polyline7 = polyline(z=h, xy: (-l1+l3-wo/2+w1/2+wo, -s_l/2+l+l2+2*w1+l3+l4) (-l1+l3-wo/2+w1/2, -s_l/2+l+l2+2*w1+l3+l4+wo) (-l1+l3-wo/2+w1/2, -s_l/2+l+l2+2*w1+l3+l4) (-l1+l3-wo/2+w1/2+wo, -s_l/2+l+l2+2*w1+l3+l4), closed, covered)
  Polyline8 = polyline(z=h, xy: (-l1+l3-wo/2+w1/2+wo+2*l1-2*l3-w1, -s_l/2+l+l2+2*w1+l3+l4) (-l1+l3-wo/2+w1/2+wo+2*l1-2*l3-w1-wo, -s_l/2+l+l2+2*w1+l3+l4) (-l1+l3-wo/2+w1/2+wo+2*l1-2*l3-w1, -s_l/2+l+l2+2*w1+l3+l4+wo) (-l1+l3-wo/2+w1/2+wo+2*l1-2*l3-w1, -s_l/2+l+l2+2*w1+l3+l4), closed, covered)
  PD2 = PD1.duplicate_along_line(step=((2*l1-2*l3-w1)/2+l5+wo, l+2*w1+l2+l3+l4+wo, 0mm), total=2)
  PD3 = PD1.duplicate_along_line(step=(-(2*l1-2*l3-w1)/2-l5-wo, l+2*w1+l2+l3+l4+wo, 0mm), total=2)
  Polyline9 = polyline(z=h, xy: (-l1+l3-wo/2+w1/2 -l5, -s_l/2+l+l2+2*w1+l3+l4+Wo) (-l1+l3-wo/2+w1/2 -l5-wo, -s_l/2+l+l2+2*w1+l3+l4+Wo) (-l1+l3-wo/2+w1/2 -l5, -s_l/2+l+l2+2*w1+l3+l4) (-l1+l3-wo/2+w1/2 -l5, -s_l/2+l+l2+2*w1+l3+l4+Wo), closed, covered)
  Polyline10 = polyline(z=h, xy: (-l1+l3-wo/2+w1/2 +l5+2*l1-2*l3-w1+wo, -s_l/2+l+l2+2*w1+l3+l4+wo) (-l1+l3-wo/2+w1/2 +l5+2*l1-2*l3-w1+wo+wo, -s_l/2+l+l2+2*w1+l3+l4+wo) (-l1+l3-wo/2+w1/2 +l5+2*l1-2*l3-w1+wo, -s_l/2+l+l2+2*w1+l3+l4) (-l1+l3-wo/2+w1/2 +l5+2*l1-2*l3-w1+wo, -s_l/2+l+l2+2*w1+l3+l4+wo), closed, covered)
  RLC2 = RLC1.duplicate_along_line(step=(-(2*l1-2*l3-w1)/2-l5-wo, l+2*w1+l2+l3+l4+wo, 0mm), total=2)
  RLC5 = RLC1.duplicate_along_line(step=((2*l1-2*l3-w1)/2+l5+wo, l+2*w1+l2+l3+l4+wo, 0mm), total=2)
  [Port2, port3].move(-(2*(2*l1-2*l3-w1)/2)-l5-2*wo-l6, 2*(l+2*w1+l2+l3+l4+wo), 0mm)
  port6 = Port2.duplicate_along_line(step=(2*((2*l1-2*l3-w1)/2+l5+wo), 0mm, 0mm), total=2)
  port7 = port3.duplicate_along_line(step=(2*((2*l1-2*l3-w1)/2+l5+wo), 0mm, 0mm), total=2)
  RadiatingSurface [vacuum] = region(absolute_offset=8.2644628mm on all sides)
  Rectangle22 = rectangle(corner=(-l1+l3-wo/2+w1/2-(2*l1-2*l3-w1)/2-l5-wo, -s_l/2+l+l2+2*w1+l4+l3+l+2*w1+l2+l3+l4+wo, h), x_size=-l6, y_size=wo)
  Rectangle22_1 = Rectangle22.duplicate_along_line(step=(2*((2*l1-2*l3-w1)/2+l5+wo), 0mm, 0mm), total=2)
  Rectangle22_2 = Rectangle22.duplicate_along_line(step=(2*l1-2*l3-w1+l6+wo, 0mm, 0mm), total=2)
  Rectangle22_1_1 = Rectangle22_1.duplicate_along_line(step=(2*l1-2*l3-w1+l6+wo, 0mm, 0mm), total=2)
  PD7 = PD2.duplicate_along_line(step=((2*l1-2*l3-w1)/2+l6+wo, l+2*w1+l2+l3+l4+wo, 0mm), total=2)
  PD6 = PD2.duplicate_along_line(step=(-((2*l1-2*l3-w1)/2+l6+wo), l+2*w1+l2+l3+l4+wo, 0mm), total=2)
  PD5 = PD3.duplicate_along_line(step=((2*l1-2*l3-w1)/2+l6+wo, l+2*w1+l2+l3+l4+wo, 0mm), total=2)
  PD4 = PD3.duplicate_along_line(step=(-((2*l1-2*l3-w1)/2+l6+wo), l+2*w1+l2+l3+l4+wo, 0mm), total=2)
  RLC3 = RLC2.duplicate_along_line(step=((2*l1-2*l3-w1)/2+l6+wo, l+2*w1+l2+l3+l4+wo, 0mm), total=2)
  RLC6 = RLC5.duplicate_along_line(step=((2*l1-2*l3-w1)/2+l6+wo, l+2*w1+l2+l3+l4+wo, 0mm), total=2)
  RLC4 = RLC2.duplicate_along_line(step=(-((2*l1-2*l3-w1)/2+l6+wo), l+2*w1+l2+l3+l4+wo, 0mm), total=2)
  RLC7 = RLC5.duplicate_along_line(step=(-((2*l1-2*l3-w1)/2+l6+wo), l+2*w1+l2+l3+l4+wo, 0mm), total=2)
  Rectangle22_ObjectFromEdge1 = object_from(PD1.edge(4 of 4))
  PD3_ObjectFromEdge1 = object_from(PD1.edge(27 of 34))
  Rectangle22_ObjectFromEdge1.connect(PD3_ObjectFromEdge1)
  Rectangle22_2_ObjectFromEdge1 = object_from(PD1.edge(2 of 4))
  PD3_ObjectFromEdge2 = object_from(PD1.edge(7 of 34))
  Rectangle22_2_ObjectFromEdge1.connect(PD3_ObjectFromEdge2)
  Rectangle22_ObjectFromEdge2 = object_from(PD1.edge(2 of 4))
  PD4_ObjectFromEdge1 = object_from(PD1.edge(17 of 34))
  Rectangle22_ObjectFromEdge2.connect(PD4_ObjectFromEdge1)
  Rectangle22_2_ObjectFromEdge2 = object_from(PD1.edge(4 of 4))
  PD5_ObjectFromEdge1 = object_from(PD1.edge(17 of 34))
  Rectangle22_2_ObjectFromEdge2.connect(PD5_ObjectFromEdge1)
  Rectangle22_1_ObjectFromEdge1 = object_from(PD1.edge(4 of 4))
  PD2_ObjectFromEdge1 = object_from(PD1.edge(27 of 34))
  Rectangle22_1_ObjectFromEdge1.connect(PD2_ObjectFromEdge1)
  Rectangle22_1_ObjectFromEdge2 = object_from(PD1.edge(2 of 4))
  PD6_ObjectFromEdge1 = object_from(PD1.edge(17 of 34))
  Rectangle22_1_ObjectFromEdge2.connect(PD6_ObjectFromEdge1)
  Rectangle22_1_1_ObjectFromEdge1 = object_from(PD1.edge(2 of 4))
  PD2_ObjectFromEdge2 = object_from(PD1.edge(7 of 34))
  Rectangle22_1_1_ObjectFromEdge1.connect(PD2_ObjectFromEdge2)
  Rectangle22_1_1_ObjectFromEdge2 = object_from(PD1.edge(4 of 4))
  PD7_ObjectFromEdge1 = object_from(PD1.edge(17 of 34))
  Rectangle22_1_1_ObjectFromEdge2.connect(PD7_ObjectFromEdge1)
  PD1.unite(PD2..PD7, Polyline7..Polyline10, Rectangle20, Rectangle20_1, Rectangle22, Rectangle22_1_1_ObjectFromEdge1, Rectangle22_1_1_ObjectFromEdge2, Rectangle22_1_ObjectFromEdge1, Rectangle22_1_ObjectFromEdge2, Rectangle22_2, Rectangle22_2_ObjectFromEdge1, Rectangle22_2_ObjectFromEdge2, Rectangle22_ObjectFromEdge1, Rectangle22_ObjectFromEdge2, Rectangle22_1_1, Rectangle22_1)
  port4 = Port2.duplicate_along_line(step=(2*((2*l1-2*l3-w1)/2+l6+wo), 0mm, 0mm), total=2)
  port5 = port3.duplicate_along_line(step=(2*((2*l1-2*l3-w1)/2+l6+wo), 0mm, 0mm), total=2)
  port8 = port6.duplicate_along_line(step=(2*((2*l1-2*l3-w1)/2+l6+wo), 0mm, 0mm), total=2)
  port9 = port7.duplicate_along_line(step=(2*((2*l1-2*l3-w1)/2+l6+wo), 0mm, 0mm), total=2)
boundaries and excitations:
  PerfE1: Perfect E Objects=PD1
  LumpRLC1: Lumped RLC Objects=RLC1 CurrentLine{(-0.85, -23.575, 0.508) -> (0.85, -23.575, 0.508)} RLC_Type=Parallel Resistance=200ohm
  PerfE2: Perfect E Objects=GroundPlane
  LumpRLC2: Lumped RLC Objects=RLC2 CurrentLine{(-12.145, -11.555, 0.508) -> (-10.445, -11.555, 0.508)} RLC_Type=Parallel Resistance=200ohm
  LumpRLC3: Lumped RLC Objects=RLC5 CurrentLine{(10.445, -11.555, 0.508) -> (12.145, -11.555, 0.508)} RLC_Type=Parallel Resistance=200ohm
  Open1: Radiation Objects=RadiatingSurface
  LumpRLC4: Lumped RLC Objects=RLC3 CurrentLine{(-5.35, 0.465, 0.508) -> (-3.65, 0.465, 0.508)} RLC_Type=Parallel Resistance=200ohm
  LumpRLC5: Lumped RLC Objects=RLC6 CurrentLine{(17.24, 0.465, 0.508) -> (18.94, 0.465, 0.508)} RLC_Type=Parallel Resistance=200ohm
  LumpRLC6: Lumped RLC Objects=RLC4 CurrentLine{(-18.94, 0.465, 0.508) -> (-17.24, 0.465, 0.508)} RLC_Type=Parallel Resistance=200ohm
  LumpRLC7: Lumped RLC Objects=RLC7 CurrentLine{(3.65, 0.465, 0.508) -> (5.35, 0.465, 0.508)} RLC_Type=Parallel Resistance=200ohm
  1: Lumped Port Objects=port1 LumpedPortType=Modal Modes{Mode1{IntLine{(0, -30, 0) -> (0, -30, 0.508)} CharImp=Zpi RenormImp=50ohm}} Impedance=50ohm
  2: Lumped Port Objects=Port2 LumpedPortType=Modal Modes{Mode1{IntLine{(-19.365, 4.54, 0) -> (-19.365, 4.54, 0.508)} CharImp=Zpi RenormImp=50ohm}} Impedance=50ohm
  3: Lumped Port Objects=port3 LumpedPortType=Modal Modes{Mode1{IntLine{(-16.815, 4.54, 0) -> (-16.815, 4.54, 0.508)} CharImp=Zpi RenormImp=50ohm}} Impedance=50ohm
  4: Lumped Port Objects=port6 LumpedPortType=Modal Modes{Mode1{IntLine{(3.225, 4.54, 0) -> (3.225, 4.54, 0.508)} CharImp=Zpi RenormImp=50ohm}} Impedance=50ohm
  5: Lumped Port Objects=port7 LumpedPortType=Modal Modes{Mode1{IntLine{(5.775, 4.54, 0) -> (5.775, 4.54, 0.508)} CharImp=Zpi RenormImp=50ohm}} Impedance=50ohm
  6: Lumped Port Objects=port4 LumpedPortType=Modal Modes{Mode1{IntLine{(-5.775, 4.54, 0) -> (-5.775, 4.54, 0.508)} CharImp=Zpi RenormImp=50ohm}} Impedance=50ohm
  7: Lumped Port Objects=port5 LumpedPortType=Modal Modes{Mode1{IntLine{(-3.225, 4.54, 0) -> (-3.225, 4.54, 0.508)} CharImp=Zpi RenormImp=50ohm}} Impedance=50ohm
  8: Lumped Port Objects=port8 LumpedPortType=Modal Modes{Mode1{IntLine{(16.815, 4.54, 0) -> (16.815, 4.54, 0.508)} CharImp=Zpi RenormImp=50ohm}} Impedance=50ohm
  9: Lumped Port Objects=port9 LumpedPortType=Modal Modes{Mode1{IntLine{(19.365, 4.54, 0) -> (19.365, 4.54, 0.508)} CharImp=Zpi RenormImp=50ohm}} Impedance=50ohm
setups:
  Setup1: HfssDriven Frequency=12.1GHz MaxDeltaS=0.01 MaximumPasses=20 MinimumPasses=1 MinimumConvergedPasses=1 PercentRefinement=30 BasisOrder=1 PortAccuracy=2 DrivenSolverType="Direct Solver"
    sweep Sweep: 11.5GHz to 13GHz, 11 points; Type=Discrete
source amplitudes:
  1:1: 1W 0deg
  2:1, 3:1, 4:1, 5:1, 6:1, 7:1, 8:1, 9:1: 0W 0deg
radiation setups:
  3D: Infinite Sphere Theta=0deg..180deg step 2deg Phi=-180deg..180deg step 2deg
  Elevation: Infinite Sphere Theta=-180deg..180deg step 1deg Phi=0deg..90deg step 90deg
  Azimuth: Infinite Sphere Theta=90deg..90deg step 0deg Phi=-180deg..180deg step 1deg
output variables:
  d = cang_deg(S(2,1))-cang_deg(S(3,1))
reports:
  VSWR Plot 1: VSWR(1) vs Freq on Setup1 : Sweep; VSWR(1), VSWR(1) vs Freq; markers m1 at 12.1GHz
  VSWR Plot 2: VSWR(2), VSWR(3), VSWR(4), VSWR(5), VSWR(6), VSWR(7), VSWR(8), VSWR(9) vs Freq on Setup1 : Sweep
  S Parameter Plot 1: dB(S(2,1)), dB(S(3,1)), dB(S(4,1)), dB(S(5,1)), dB(S(6,1)), dB(S(7,1)), dB(S(8,1)), dB(S(9,1)) vs Freq on Setup1 : Sweep
  S Parameter Plot 2: dB(S(3,2)), dB(S(4,2)), dB(S(5,2)), dB(S(6,2)), dB(S(7,2)), dB(S(8,2)), dB(S(9,2)), dB(S(4,3)), dB(S(5,3)), dB(S(6,3)), dB(S(7,3)), dB(S(8,3)), dB(S(9,3)), dB(S(5,4)), dB(S(6,4)), dB(S(7,4)), dB(S(8,4)), dB(S(9,4)), dB(S(6,5)), dB(S(7,5)), dB(S(8,5)), dB(S(9,5)), dB(S(7,6)), dB(S(8,6)), dB(S(9,6)), dB(S(8,7)), dB(S(9,7)), dB(S(8,9)) vs Freq on Setup1 : Sweep
  VSWR Plot 3: VSWR(1) vs Freq on Setup1 : Sweep [l5=8mm,8.5mm l6=4mm]
